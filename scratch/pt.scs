simulator lang=spectre
include "/home/install/FOUNDRY/analog/180nm/models/spectre/gpdk.scs" section=NN
opt options soft_bin=allmodels save=allpub subcktprobelvl=2
Vdd (vdd 0) vsource dc=0.9
Vss (vss 0) vsource dc=-0.9
Vin_p (inp 0) vsource dc=0 mag=1
Vin_m (inm 0) vsource dc=0 mag=0

Ibias (vdd nbias) isource dc=30u
M8 (nbias nbias vss vss) nmos1 w=160u l=0.18u as=160u*0.36u ad=160u*0.36u ps=2*(160u+0.36u) pd=2*(160u+0.36u)
M5 (tail nbias vss vss) nmos1 w=160u l=0.18u as=160u*0.36u ad=160u*0.36u ps=2*(160u+0.36u) pd=2*(160u+0.36u)
M1 (net_m3 inm tail vss) nmos1 w=3.4u l=0.18u as=3.4u*0.36u ad=3.4u*0.36u ps=2*(3.4u+0.36u) pd=2*(3.4u+0.36u)
M2 (net_m4 inp tail vss) nmos1 w=3.4u l=0.18u as=3.4u*0.36u ad=3.4u*0.36u ps=2*(3.4u+0.36u) pd=2*(3.4u+0.36u)
M3 (net_m3 net_m3 vdd vdd) pmos1 w=10.0u l=0.18u as=10.0u*0.36u ad=10.0u*0.36u ps=2*(10.0u+0.36u) pd=2*(10.0u+0.36u)
M4 (net_m4 net_m3 vdd vdd) pmos1 w=10.0u l=0.18u as=10.0u*0.36u ad=10.0u*0.36u ps=2*(10.0u+0.36u) pd=2*(10.0u+0.36u)

M6 (vout net_m4 vdd vdd) pmos1 w=20u l=0.18u as=20u*0.36u ad=20u*0.36u ps=2*(20u+0.36u) pd=2*(20u+0.36u)
M7 (vout nbias vss vss) nmos1 w=160u l=0.18u as=160u*0.36u ad=160u*0.36u ps=2*(160u+0.36u) pd=2*(160u+0.36u)
Cc (net_m4 vout) capacitor c=1.5p
CL (vout 0) capacitor c=10p

dcOp dc
opInfo info what=oppoint where=rawfile
acSwp ac start=1 stop=100M dec=20
