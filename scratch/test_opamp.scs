simulator lang=spectre
include "/home/install/FOUNDRY/analog/180nm/models/spectre/gpdk.scs" section=NN

parameters Wdiff=3.4u Wnb=160u Wpo=5.5u Wbp=30u Cc=1.5p L=0.18u

saveOptions options save=allpub subcktprobelvl=2

// Power supplies
Vdd (vdd 0) vsource dc=0.9
Vss (vss 0) vsource dc=-0.9

// Input sources: CM = 0V, AC mag = 1 on INP, 0 on INM
Vin_p (inp 0) vsource dc=0 mag=1
Vin_m (inm 0) vsource dc=0 mag=0

// Ideal current source Io = 30uA into diode-connected bias branch
// From Vdd to bias node nbias
Ibias (vdd nbias) isource dc=30u

// Bias transistor M8 (NMOS)
M8 (nbias nbias vss vss) nmos1 w=Wnb l=L

// Differential pair tail transistor M5 (NMOS)
M5 (tail nbias vss vss) nmos1 w=Wnb l=L

// Differential pair M1, M2 (NMOS)
M1 (net_m3 inm tail vss) nmos1 w=Wdiff l=L
M2 (net_m4 inp tail vss) nmos1 w=Wdiff l=L

// Active mirror load M3, M4 (PMOS)
M3 (net_m3 net_m3 vdd vdd) pmos1 w=Wbp l=L
M4 (net_m4 net_m3 vdd vdd) pmos1 w=Wbp l=L

// Second stage: PMOS common-source M6, NMOS load M7
M6 (vout net_m4 vdd vdd) pmos1 w=Wpo l=L
M7 (vout nbias vss vss) nmos1 w=Wnb l=L

// Miller compensation capacitor
Cc (net_m4 vout) capacitor c=Cc

// Load capacitor CL = 10pF from output to ground
CL (vout 0) capacitor c=10p

// Analyses
dcOp dc
opInfo info what=oppoint where=rawfile
acSwp ac start=1 stop=100M dec=20
