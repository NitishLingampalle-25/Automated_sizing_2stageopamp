simulator lang=spectre
include "/home/install/FOUNDRY/analog/180nm/models/spectre/gpdk.scs" section=NN

saveOptions options save=allpub subcktprobelvl=2
Vdd (vdd 0) vsource dc=1.8
M2 (0 0 vdd vdd) pmos1 w=2u l=0.18u

dcOp dc
opInfo info what=oppoint where=rawfile
