simulator lang=spectre
include "/home/install/FOUNDRY/analog/180nm/models/spectre/gpdk.scs" section=NN
opt options soft_bin=allmodels save=allpub subcktprobelvl=2
Vdd (vdd 0) vsource dc=0.9
Vss (vss 0) vsource dc=-0.9
Vin_p (inp 0) vsource dc=0 mag=1
Vin_m (inm 0) vsource dc=0 mag=0

// PMOS bias mirror branch: Io = 30u from pbias to vss
Ibias (pbias vss) isource dc=30u
M8 (pbias pbias vdd vdd) pmos1 w=30u l=0.18u

// PMOS tail transistor M5
M5 (tail pbias vdd vdd) pmos1 w=30u l=0.18u

// PMOS diff pair M1, M2
M1 (net_m3 inm tail vdd) pmos1 w=3.4u l=0.18u
M2 (net_m4 inp tail vdd) pmos1 w=3.4u l=0.18u

// NMOS mirror load M3, M4
M3 (net_m3 net_m3 vss vss) nmos1 w=160u l=0.18u
M4 (net_m4 net_m3 vss vss) nmos1 w=160u l=0.18u

// Second stage: NMOS common-source M6, PMOS load M7
M6 (vout net_m4 vss vss) nmos1 w=160u l=0.18u
M7 (vout pbias vdd vdd) pmos1 w=5.5u l=0.18u
Cc (net_m4 vout) capacitor c=1.5p
CL (vout 0) capacitor c=10p

dcOp dc
opInfo info what=oppoint where=rawfile
acSwp ac start=1 stop=100M dec=20
